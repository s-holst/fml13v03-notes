// EIC770x OTP Controller (OTPC) register file
// Source: fml13v03_u-boot/include/eswin/es_otp_map.h
// OTPC base: 0x21B40000 (SCPU view) / 0x51B40000 (MCPU alias)
//
// Note: offsets 0x00–0x13 are undocumented; first known register is at 0x14.

regfile otp_rf {
    name = "OTPC";
    desc = "OTP Controller — programs and reads the one-time-programmable fuse array.
            Trigger reads by writing rd_addr_size then the magic word 0x6ACCACC6 to cmd_word.
            Trigger writes by writing wr_data_mask then 0x9ACCACC9 to cmd_word.
            Trigger pgm-lock by writing 0x10C610C6 to cmd_word.";

    default sw = rw;
    default hw = r;

    // 0x14 — read address and length
    reg {
        desc = "OTP read base address, byte count, and XOR mode";
        field {} rd_4bitxor1bit_en[24:24] = 1'b0; // enable 4-bit→1-bit XOR error correction on read
        field {} rd_length[23:16]         = 8'h0;  // number of bytes to read (max 128)
        field {} rd_base_addr[15:0]       = 16'h0; // OTP byte address of first byte to read
    } rd_addr_size @ 0x14;

    // 0x18 — read data FIFO output (read repeatedly until rd_last=1)
    reg {
        desc = "OTP read packet FIFO — read once per byte until rd_last asserts";
        default sw = r;
        field {} rd_valid[12:12] = 1'b0; // 1 = rd_data contains valid data
        field {} rd_last[8:8]    = 1'b0; // 1 = this is the last byte of the requested burst
        field {} rd_data[7:0]    = 8'h0; // read data byte
    } rd_packet @ 0x18;

    // 0x1C — operation completion/error status (sticky; clear via clear_status_int)
    reg {
        desc = "OTP operation status flags (sticky; clear with clear_status_int)";
        default sw = r;
        field {} rdone_st[10:10]   = 1'b0; // read-done
        field {} pgmlock_st[9:9]   = 1'b0; // program-lock done
        field {} wrdone_st[8:8]    = 1'b0; // write-done
        field {} wrfail_st[7:0]    = 8'h0; // write-fail bits (one per failed bit-cell attempt)
    } op_status @ 0x1c;

    // 0x20 — write 1 to clear each status flag
    reg {
        desc = "Clear op_status sticky flags — write 1 to each bit to clear";
        field {sw = w;} clr_pgmlock[3:3] = 1'b0; // clear pgmlock_st
        field {sw = w;} clr_wrfail[2:2]  = 1'b0; // clear wrfail_st
        field {sw = w;} clr_wrdone[1:1]  = 1'b0; // clear wrdone_st
        field {sw = w;} clr_rdone[0:0]   = 1'b0; // clear rdone_st
    } clear_status_int @ 0x20;

    // 0x30 — global control
    reg {
        desc = "OTPC global control — enables, interrupt masks, DUT/JTAG access";
        field {} progfail_int_en[9:9]    = 1'b0; // enable program-fail interrupt
        field {} jtag2apb_acc[8:8]       = 1'b0; // allow JTAG-to-APB OTP access
        field {} clear_dut[7:7]          = 1'b0; // clear DUT state
        field {} pgmlock_done_inten[6:6] = 1'b0; // enable pgm-lock-done interrupt
        field {} rdone_int_en[5:5]       = 1'b0; // enable read-done interrupt
        field {} wrdone_int_en[4:4]      = 1'b0; // enable write-done interrupt
        field {} clean_readbuf[3:3]      = 1'b0; // flush internal read buffer
        field {} pgmlock_en[2:2]         = 1'b0; // enable program-lock mode
        field {} init_otp[0:0]           = 1'b0; // initialize OTP IP (pulse high to start)
    } glb_ctrl @ 0x30;

    // 0x34 — command trigger (write-only magic word)
    //   Read trigger:    0x6ACCACC6  (RD_START_WORD)
    //   Write trigger:   0x9ACCACC9  (WR_START_WORD)
    //   Pgm-lock trigger: 0x10C610C6 (PGMLOCK_START_WORD)
    reg {
        desc = "Command word — write magic value to trigger read/write/pgmlock operation.
                0x6ACCACC6 = read, 0x9ACCACC9 = write, 0x10C610C6 = program-lock";
        field {sw = w;} cmd_word[31:0] = 32'h0;
    } cmd_word @ 0x34;

    // 0x38 — OTP IP status (RO)
    reg {
        desc = "OTP IP status flags";
        default sw = r;
        field {} otp_init_done[3:3] = 1'b0; // IP initialization complete
        field {} otp_bit_lock[2:2]  = 1'b0; // individual bit-cell locked
        field {} otp_pgm_lock[1:1]  = 1'b0; // entire array program-locked
        field {} otp_busy[0:0]      = 1'b0; // operation in progress
    } status @ 0x38;

    // 0x3C — chip-level OTP status latched at POR (RO)
    reg {
        desc = "Chip control — OTP values latched at power-on reset";
        default sw = r;
        field {} otp_jtag2apb_disable[21:20] = 2'b0; // JTAG-to-APB access disable (2-bit)
        field {} otp_padacc_disable[19:19]   = 1'b0; // OTP pad access disable
        field {} scpu_jtag_disable[18:18]    = 1'b0; // SCPU JTAG disable
        field {} secure_mode[17:17]          = 1'b0; // chip is in secure boot mode
        field {} por_otprd_done[16:16]       = 1'b0; // POR OTP shadow read complete
        field {} die_ordinal[15:8]           = 8'h0; // ordinal of this die in a multi-die package
        field {} die_num[7:0]                = 8'h0; // total number of dies
    } chip_ctrl @ 0x3c;

    // 0x40 — programming pulse configuration
    reg {
        desc = "NP pulse count configuration for OTP programming";
        field {} cap_d0_mode[12:12] = 1'b0;  // capacitor D0 charge mode
        field {} np2_num[9:4]       = 6'h02; // NP2 pulse count (default 2)
        field {} np1_num[1:0]       = 2'h0;  // NP1 pulse count
    } np_pulse_num @ 0x40;

    // 0x44 — write data, bit-enable mask, and target address
    reg {
        desc = "OTP write data, bit-enable mask, and target address";
        field {} wr_addr[31:16]  = 16'h0; // OTP byte address to write
        field {} wr_biten[15:8]  = 8'h0;  // bit-enable mask (1 = allow programming that bit)
        field {} wr_data[7:0]    = 8'h0;  // data byte to write
    } wr_data_mask @ 0x44;

}; // otp_rf


