`include "syscrg_rf.rdl"
`include "syscon_rf.rdl"
`include "otpc_rf.rdl"

regfile clint_rf {
    reg {
        field {} data[31:0];
    } msip @ 0;
    reg {
        regwidth=64;
        field {} data[63:0];
    } mtimecmp @ 0x4000;
    reg {
        regwidth=64;
        field {} data[63:0];
    } mtime @ 0xbff8;
};

regfile plic_rf {
    name = "SCPU security peripherals (0x21Bxxxxx = SCPU view; MCPU alias at 0x51Bxxxxx)";
    reg {
        field {} data[31:0];
    } TODO @ 0;
};


regfile bootspi_rf {
    name = "SPI flash controller [boot-path only]";
    reg {
        field {} data[31:0];
    } TODO @ 0;
};


regfile spacc_rf {
    name = "Synopsys DesignWare Security Protocol Accelerator (AES, SM4)";
    reg {
        field {} TODO[31:0];
    } TODO @ 0;
};

regfile pka_rf {
    name = "Synopsys DesignWare Public Key Accelerator (RSA, ECDSA)";
    reg {
        field {} TODO[31:0];
    } TODO @ 0;
};

regfile trng_rf {
    name = "Synopsys DesignWare True Random Number Generator";
    reg {
        field {} TODO[31:0];
    } TODO @ 0;
};

regfile otp_shadow_rf {
    name = "OTP shadow / secure identity registers (~0x190 bytes)";
    reg {
        field {} TODO[31:0];
    } TODO @ 0;
    reg {
        field {name = "ESWIN vendor ID string written at boot step 4";} vendor_id[31:0];
    } vendor_id @ 0x170;
};

regfile pmp_rf {
    name = "Physical Memory Protection unit (Synopsys DesignWare; FUN_ram_58007ed4)";
    reg {
        field {} TODO[31:0];
    } TODO @ 0;
};

regfile hsp_csr_rf {
    name = "High-Speed Peripheral subsystem SP CSR [boot-path only]";
    reg {
        field {} TODO[31:0];
    } TODO @ 0;
};

regfile sdhci_rf {
    name = "SDHCI eMMC controller [boot-path only]";
    reg {
        field {} TODO[31:0];
    } TODO @ 0;
};

regfile usbdrd_rf {
    name = "USB 3.0 DRD controller [boot-path only]";
    reg {
        field {} TODO[31:0];
    } TODO @ 0;
};

regfile uart_rf #(string NAME = "Synopsys DW APB UART, 16550-compatible") {
    name = NAME;
    reg {
        field {} TODO[31:0];
    } TODO @ 0;
};

regfile mbox_rf #(string NAME = "U84 (MCPU) → SCPU mailbox [boot-path only]") {
    name = NAME;
    reg {
        field {} TODO[31:0];
    } TODO @ 0;
};

regfile pinctrl_rf {
    name = "Pin controller [boot-path only]";
    reg {
        field {} TODO[31:0];
    } TODO @ 0;
};


regfile timer_rf #(string NAME = "Timer [boot-path only]") {
    name = NAME;
    reg {
        field {} TODO[31:0];
    } TODO @ 0;
};

regfile coda_llc_rf {
    name = "CodaCache LLC controller (NPU LLC)";
    desc = "Reconfigured to SPRAM during boot; see coda_llc_spram_init() / FUN_ram_58007ce8";
    reg {
        field {} TODO[31:0];
    } TODO @ 0;
    reg {
        field {name = "1=busy, 0=ready";} busy[0:0];
    } status @ 0x100;
    reg {
        field {name = "0xffff=init valid entries, 0x10000=TagArray";} op[31:0];
    } ccucmwvr @ 0x118;
};

regfile dw_axidma_rf #(string NAME = "DW AXI DMA channel control (NPU LLC DMA)") {
    name = NAME;
    reg {
        field {} TODO[31:0];
    } TODO @ 0;
    reg {
        field {} ch1_ctl[31:0];
    } ch1_ctl @ 0x118;
};

regfile d2d_rf {
    name = "Die-to-Die subsystem [boot-path only]";
    reg {
        field {} TODO[31:0];
    } TODO @ 0;
    reg {
        field {} data[31:0];
    } firmware1[0x4000] @ 0x50000;
    reg {
        field {} data[31:0];
    } firmware2[0x4000] @ 0x60000;
};

regfile ddrctl_rf #(string NAME = "DDR controller [boot-path only]") {
    name = NAME;
    reg {
        field {} TODO[31:0];
    } TODO @ 0;
};

regfile ddrphy_rf #(string NAME = "DDR PHY [boot-path only]") {
    name = NAME;
    reg {
        field {} TODO[31:0];
    } TODO @ 0;
};

regfile unknown_rf #(string NAME = "") {
    name = NAME;
    reg {
        field {} TODO[31:0];
    } TODO @ 0;
};

regfile pcie_ctrl_rf {
    name = "PCIe wrapper config space";
    reg { field {} TODO[31:0]; } TODO @ 0;
};

regfile pcie_ip_rf {
    name = "PCIe IP DBI config space";
    reg { field {} TODO[31:0]; } TODO @ 0;
};

regfile vdec_rf {
    name = "Video Decoder";
    reg { field {} TODO[31:0]; } TODO @ 0;
};

regfile venc_rf {
    name = "Video Encoder";
    reg { field {} TODO[31:0]; } TODO @ 0;
};

regfile jdec_rf {
    name = "JPEG Decoder";
    reg { field {} TODO[31:0]; } TODO @ 0;
};

regfile jenc_rf {
    name = "JPEG Encoder";
    reg { field {} TODO[31:0]; } TODO @ 0;
};

regfile g2d_rf #(string NAME = "Vivante gc820 2D GPU core") {
    name = NAME;
    reg { field {} TODO[31:0]; } TODO @ 0;
};

regfile vc_csr_rf {
    name = "Video Codec CSR";
    reg { field {} TODO[31:0]; } TODO @ 0;
};

regfile i2s_rf #(string NAME = "") {
    name = NAME;
    reg { field {} TODO[31:0]; } TODO @ 0;
};

regfile dsi_rf {
    name = "Synopsys DW DSI controller";
    reg { field {} TODO[31:0]; } TODO @ 0;
};

regfile vo_csr_rf {
    name = "VO CSR";
    reg { field {} TODO[31:0]; } TODO @ 0;
};

regfile hdmi_hdcp_rf {
    name = "Synopsys DW HDMI HDCP2";
    reg { field {} TODO[31:0]; } TODO @ 0;
};

regfile hdmi_rf {
    name = "Synopsys DW HDMI";
    reg { field {} TODO[31:0]; } TODO @ 0;
};

regfile dc_rf {
    name = "Display controller (DC8200)";
    reg { field {} TODO[31:0]; } TODO @ 0;
};

regfile gmac_rf #(string NAME = "Ethernet MAC (GMAC)") {
    name = NAME;
    reg { field {} TODO[31:0]; } TODO @ 0;
};

regfile sata_rf {
    name = "SATA";
    reg { field {} TODO[31:0]; } TODO @ 0;
};

regfile dma_rf {
    name = "DMA0 controller";
    reg { field {} TODO[31:0]; } TODO @ 0;
};

regfile sdio_rf #(string NAME = "") {
    name = NAME;
    reg { field {} TODO[31:0]; } TODO @ 0;
};

regfile wdt_rf #(string NAME = "Watchdog timer") {
    name = NAME;
    reg { field {} TODO[31:0]; } TODO @ 0;
};

regfile spi_rf #(string NAME = "") {
    name = NAME;
    reg { field {} TODO[31:0]; } TODO @ 0;
};

regfile pwm_rf {
    name = "PWM";
    reg { field {} TODO[31:0]; } TODO @ 0;
};

regfile i2c_rf #(string NAME = "") {
    name = NAME;
    reg { field {} TODO[31:0]; } TODO @ 0;
};

regfile pmu_rf {
    name = "PMU";
    reg { field {} TODO[31:0]; } TODO @ 0;
};

regfile rtc_rf {
    name = "RTC";
    reg { field {} TODO[31:0]; } TODO @ 0;
};

regfile pvt_rf {
    name = "PVT (Process-Voltage-Temperature) monitor";
    reg { field {} TODO[31:0]; } TODO @ 0;
};

regfile fan_rf {
    name = "Fan control";
    reg { field {} TODO[31:0]; } TODO @ 0;
};

regfile smmu_rf {
    name = "SMMU";
    reg { field {} TODO[31:0]; } TODO @ 0;
};

regfile isp_rf #(string NAME = "") {
    name = NAME;
    reg { field {} TODO[31:0]; } TODO @ 0;
};

regfile dewrap_rf {
    name = "Dewarp/lens-correction engine";
    reg { field {} TODO[31:0]; } TODO @ 0;
};

regfile vi_csr_rf {
    name = "VI Top CSR";
    reg { field {} TODO[31:0]; } TODO @ 0;
};

regfile csi2_rf #(string NAME = "MIPI CSI-2 receiver") {
    name = NAME;
    reg { field {} TODO[31:0]; } TODO @ 0;
};

regfile dphy_rf #(string NAME = "MIPI D-PHY") {
    name = NAME;
    reg { field {} TODO[31:0]; } TODO @ 0;
};

regfile gpu_rf {
    name = "GPU (P550 / SiFive Intelligence X280)";
    reg { field {} TODO[31:0]; } TODO @ 0;
};

regfile noc_rf {
    name = "System NoC configuration space (packet/trans probes, QoS settings, filters)";
    reg { field {} TODO[31:0]; } TODO @ 0;
};

regfile dsp_sub_rf {
    name = "DSP subsystem (es-dsp-subsys)";
    reg { field {} TODO[31:0]; } TODO @ 0;
};

mem aon_tim_m {
    name = "AON Timer SRAM window (size TBD)";
    mementries = 0x2000;
    memwidth = 32;
};

mem dsp_sram_m {
    name = "DSP SRAM (size TBD)";
    mementries = 0x10000;
    memwidth = 32;
};

mem pka_sram_m {
    name = "PKA instruction SRAM";
    mementries = 0x1000;
    memwidth = 32;
};

mem sram_m #(string NAME = "SCPU TIM SRAM") {
    name = NAME;
    mementries = 0x2000;
    memwidth = 32;
};

mem mrom_m {
    name = "SCPU masked ROM";
    mementries = 0x8000;
    memwidth = 32;
};

mem coda_m #(string NAME = "CodaCache SPRAM (boot load target)") {
    name = NAME;
    mementries = 0x100000;
    memwidth = 32;
};

mem nor_flash_m {
    name = "SPI NOR XIP window";
    mementries = 0x1000000;
    memwidth = 32;
};

addrmap scpu_memory {
    name = "SCPU Memory";
    desc = "Memory map of the SCPU within the EIC770x SoC";

    clint_rf   clint   @ 0x02000000;
    plic_rf    plic    @ 0x0c000000;
    spacc_rf      spacc      @ 0x21900000;
    pka_rf        pka        @ 0x21b00000;
    external pka_sram_m pka_sram @ 0x21b04000;
    trng_rf       trng       @ 0x21b08000;
    otp_rf        otp        @ 0x21b40000;
    otp_shadow_rf otp_shadow @ 0x21b48000;
    pmp_rf pmp0 @ 0x21b80000;
    pmp_rf pmp1 @ 0x21b88000;
    pmp_rf pmp2 @ 0x21b90000;
    pmp_rf pmp3 @ 0x21b98000;
    pmp_rf pmp4 @ 0x21ba0000;
    pmp_rf pmp5 @ 0x21bb0000;
    pmp_rf pmp6 @ 0x21bb8000;
    pmp_rf pmp7 @ 0x21bc0000;
    pmp_rf pmp8 @ 0x21bc8000;
    pmp_rf pmp9 @ 0x21bd0000;

    external sram_m sram_tim @ 0x30000000;

    hsp_csr_rf hsp_csr  @ 0x50440000;
    sdhci_rf   sdhci    @ 0x50450000;
    usbdrd_rf  usbdrd0  @ 0x50480000;
    usbdrd_rf  usbdrd1  @ 0x50490000;
    uart_rf #(.NAME("DW APB UART0, primary boot console")) uart0    @ 0x50900000;
    uart_rf #(.NAME("UART1 [boot-path only]")) uart1    @ 0x50910000;
    mbox_rf #(.NAME("U84→SCPU mailbox [boot-path only]")) mbox     @ 0x50a00000;
    pinctrl_rf pinctrl  @ 0x51600000;

    bootspi_rf  bootspi  @ 0x51800000;
    syscon_rf   syscon   @ 0x51810000;
    unknown_rf #(.NAME("? AON domain [boot-path only], likely AONCRG or PMCRG")) aon_crg  @ 0x51820000;
    syscrg_rf   syscrg   @ 0x51828000;
    timer_rf #(.NAME("TIMER0 [boot-path only]")) timer0   @ 0x51840000;
    unknown_rf #(.NAME("? may be SPAcc MCPU-alias or second instance [boot-path only]")) scpu_per @ 0x51900000;

    coda_llc_rf  coda_llc  @ 0x51c00000;
    dw_axidma_rf #(.NAME("NPU LLC0 DW AXI DMA")) coda_dma0 @ 0x51d88000;
    dw_axidma_rf #(.NAME("NPU LLC1 DW AXI DMA")) coda_dma1 @ 0x51d89000;

    d2d_rf    d2d     @ 0x52100000;
    ddrctl_rf #(.NAME("DDR Controller 0 [boot-path only]")) ddrctl0 @ 0x52300000;
    ddrctl_rf #(.NAME("DDR Controller 1 [boot-path only]")) ddrctl1 @ 0x52380000;
    ddrphy_rf #(.NAME("DDR PHY 0 [boot-path only]")) ddrphy0 @ 0x53000000;
    ddrphy_rf #(.NAME("DDR PHY 1 [boot-path only]")) ddrphy1 @ 0x53800000;

    pcie_ctrl_rf pcie_ctrl @ 0x50000000;

    // Video Codec block (0x50100000–0x501c0000)
    vdec_rf  vdec   @ 0x50100000;
    venc_rf  venc   @ 0x50110000;
    jdec_rf  jdec   @ 0x50120000;
    jenc_rf  jenc   @ 0x50130000;
    g2d_rf #(.NAME("gc820 2D GPU core 0")) g2d0   @ 0x50140000;
    g2d_rf #(.NAME("gc820 2D GPU core 1")) g2d1   @ 0x50180000;
    vc_csr_rf vc_csr @ 0x501c0000;

    // Video Output block (0x50200000–0x502d0000)
    i2s_rf #(.NAME("I2S0")) i2s0      @ 0x50200000;
    i2s_rf #(.NAME("I2S1")) i2s1      @ 0x50210000;
    i2s_rf #(.NAME("I2S2")) i2s2      @ 0x50220000;
    dsi_rf      dsi       @ 0x50270000;
    vo_csr_rf   vo_csr    @ 0x50280000;
    hdmi_hdcp_rf hdmi_hdcp @ 0x50290000;
    hdmi_rf     hdmi      @ 0x502a0000;
    dc_rf       dc        @ 0x502c0000;

    // High Speed peripherals (0x50400000–0x50500000)
    gmac_rf #(.NAME("GMAC0")) gmac0 @ 0x50400000;
    gmac_rf #(.NAME("GMAC1")) gmac1 @ 0x50410000;
    sata_rf sata  @ 0x50420000;
    dma_rf  dma0  @ 0x50430000;
    // hsp_csr/sdhci/usbdrd0-1 already instantiated above
    sdio_rf #(.NAME("SDIO0")) sdio0 @ 0x50460000;
    sdio_rf #(.NAME("SDIO1")) sdio1 @ 0x50470000;

    // Low Speed peripherals apb2 (0x50800000–0x50900000)
    wdt_rf #(.NAME("Watchdog 0")) wdt0 @ 0x50800000;
    wdt_rf #(.NAME("Watchdog 1")) wdt1 @ 0x50804000;
    wdt_rf #(.NAME("Watchdog 2")) wdt2 @ 0x50808000;
    wdt_rf #(.NAME("Watchdog 3")) wdt3 @ 0x5080c000;
    spi_rf #(.NAME("SPI0")) spi0 @ 0x50810000;
    spi_rf #(.NAME("SPI1")) spi1 @ 0x50814000;
    pwm_rf pwm  @ 0x50818000;

    // Low Speed peripherals apb3 (0x50900000–0x50a00000)
    // uart0/1 already instantiated above
    uart_rf #(.NAME("UART2")) uart2 @ 0x50920000;
    uart_rf #(.NAME("UART3")) uart3 @ 0x50930000;
    uart_rf #(.NAME("UART4")) uart4 @ 0x50940000;
    i2c_rf #(.NAME("I2C0")) i2c0  @ 0x50950000;
    i2c_rf #(.NAME("I2C1")) i2c1  @ 0x50960000;
    i2c_rf #(.NAME("I2C2")) i2c2  @ 0x50970000;
    i2c_rf #(.NAME("I2C3")) i2c3  @ 0x50980000;
    i2c_rf #(.NAME("I2C4")) i2c4  @ 0x50990000;
    i2c_rf #(.NAME("I2C5")) i2c5  @ 0x509a0000;
    i2c_rf #(.NAME("I2C6")) i2c6  @ 0x509b0000;
    i2c_rf #(.NAME("I2C7")) i2c7  @ 0x509c0000;
    i2c_rf #(.NAME("I2C8")) i2c8  @ 0x509d0000;
    i2c_rf #(.NAME("I2C9")) i2c9  @ 0x509e0000;

    // Low Speed peripherals apb4 (0x50a00000–0x50b00000) — mailboxes
    // mbox (U84→SCPU) already instantiated above at 0x50a00000
    mbox_rf #(.NAME("SCPU → U84")) mbox_scpu_to_u84  @ 0x50a10000;
    mbox_rf #(.NAME("U84 → LCPU")) mbox_u84_to_lcpu  @ 0x50a20000;
    mbox_rf #(.NAME("LCPU → U84")) mbox_lcpu_to_u84  @ 0x50a30000;
    mbox_rf #(.NAME("U84 → NPU0")) mbox_u84_to_npu0  @ 0x50a40000;
    mbox_rf #(.NAME("NPU0 → U84")) mbox_npu0_to_u84  @ 0x50a50000;
    mbox_rf #(.NAME("U84 → NPU1")) mbox_u84_to_npu1  @ 0x50a60000;
    mbox_rf #(.NAME("NPU1 → U84")) mbox_npu1_to_u84  @ 0x50a70000;
    mbox_rf #(.NAME("U84 → DSP0")) mbox_u84_to_dsp0  @ 0x50a80000;
    mbox_rf #(.NAME("DSP0 → U84")) mbox_dsp0_to_u84  @ 0x50a90000;
    mbox_rf #(.NAME("U84 → DSP1")) mbox_u84_to_dsp1  @ 0x50aa0000;
    mbox_rf #(.NAME("DSP1 → U84")) mbox_dsp1_to_u84  @ 0x50ab0000;
    mbox_rf #(.NAME("U84 → DSP2")) mbox_u84_to_dsp2  @ 0x50ac0000;
    mbox_rf #(.NAME("DSP2 → U84")) mbox_dsp2_to_u84  @ 0x50ad0000;
    mbox_rf #(.NAME("U84 → DSP3")) mbox_u84_to_dsp3  @ 0x50ae0000;
    mbox_rf #(.NAME("DSP3 → U84")) mbox_dsp3_to_u84  @ 0x50af0000;

    // Low Speed peripherals apb6 (0x50b00000–0x50c00000)
    pvt_rf pvt0 @ 0x50b00000;
    fan_rf fan  @ 0x50b50000;

    // SMMU (0x50c00000–0x51000000)
    smmu_rf smmu @ 0x50c00000;

    // Video Input block (0x51000000–0x51200000)
    isp_rf #(.NAME("ISP0")) isp0    @ 0x51000000;
    isp_rf #(.NAME("ISP1")) isp1    @ 0x51010000;
    dewrap_rf dewrap  @ 0x51020000;
    vi_csr_rf vi_csr  @ 0x51030000;
    csi2_rf #(.NAME("MIPI CSI-2 receiver 0")) csi2_0  @ 0x51050000;
    csi2_rf #(.NAME("MIPI CSI-2 receiver 1")) csi2_1  @ 0x51060000;
    csi2_rf #(.NAME("MIPI CSI-2 receiver 2")) csi2_2  @ 0x51070000;
    csi2_rf #(.NAME("MIPI CSI-2 receiver 3")) csi2_3  @ 0x51080000;
    csi2_rf #(.NAME("MIPI CSI-2 receiver 4")) csi2_4  @ 0x51090000;
    csi2_rf #(.NAME("MIPI CSI-2 receiver 5")) csi2_5  @ 0x510a0000;
    dphy_rf #(.NAME("MIPI D-PHY 0")) dphy0   @ 0x510c0000;
    dphy_rf #(.NAME("MIPI D-PHY 1")) dphy1   @ 0x510e0000;
    dphy_rf #(.NAME("MIPI D-PHY 2")) dphy2   @ 0x51100000;
    dphy_rf #(.NAME("MIPI D-PHY 3")) dphy3   @ 0x51120000;
    dphy_rf #(.NAME("MIPI D-PHY 4")) dphy4   @ 0x51140000;
    dphy_rf #(.NAME("MIPI D-PHY 5")) dphy5   @ 0x51160000;

    // GPU (0x51400000–0x51600000)
    gpu_rf gpu @ 0x51400000;

    // pinctrl already instantiated above at 0x51600000

    // AON additions (0x51808000–0x51858000)
    pmu_rf pmu        @ 0x51808000;
    // syscon already at 0x51810000
    rtc_rf rtc        @ 0x51818000;
    // aon_crg/syscrg already instantiated above
    i2c_rf #(.NAME("AON I2C0")) i2c_aon0   @ 0x51830000;
    i2c_rf #(.NAME("AON I2C1")) i2c_aon1   @ 0x51838000;
    // timer0 already at 0x51840000
    timer_rf #(.NAME("TIMER1")) timer1   @ 0x51848000;
    timer_rf #(.NAME("TIMER2")) timer2   @ 0x51850000;
    timer_rf #(.NAME("TIMER3")) timer3   @ 0x51858000;

    // security peripherals at 0x51Bxxxxx already instantiated above (SCPU-view)
    // scpu_per at 0x51900000 already instantiated above

    // coda_llc/coda_dma already instantiated above

    // NoC configuration space (0x52000000–0x52100000)
    noc_rf noc @ 0x52000000;

    // d2d already at 0x52100000

    // DSP subsystem (0x52200000–0x52300000)
    dsp_sub_rf dsp_subsys @ 0x52200000;

    // ddrctl0/1 already at 0x52300000/0x52380000
    // ddrphy0/1 already at 0x53000000/0x53800000

    // PCIe IP DBI registers (0x54000000–0x58000000)
    pcie_ip_rf pcie_ip @ 0x54000000;

    external mrom_m     masked_rom    @ 0x58000000;
    external sram_m #(.NAME("SCPU TIM remap alias")) scpu_tim_remap @ 0x58500000;
    external aon_tim_m  aon_tim        @ 0x58800000;
    external coda_m #(.NAME("CodaCache0 SPRAM boot load target")) coda_cache     @ 0x59000000;
    external coda_m #(.NAME("CodaCache1 SPRAM (NPU)")) coda1_cache    @ 0x5a000000;
    external dsp_sram_m dsp_sram       @ 0x5b000000;
    external nor_flash_m nor_flash     @ 0x5c000000;

}; // scpu_memory